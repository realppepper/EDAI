* 블록: 캐스코드 게이트 바이어스
* 단자: VDD VSS NB PB VBN VBP
* VBN 은 NMOS 캐스코드의 게이트 전압, VBP 는 PMOS 캐스코드의 게이트 전압.
XMB5 VBN PB  VDD VDD pfet_06v0 w=24u l=2u
XMB6 VBN VBN VSS VSS nfet_06v0 w=1.2u l=2u
XMB7 VBP NB  VSS VSS nfet_06v0 w=11.5u l=2u
XMB8 VBP VBP VDD VDD pfet_06v0 w=5u l=2u
