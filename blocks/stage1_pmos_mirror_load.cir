* 블록: 1단 - PMOS 입력 차동쌍 + NMOS 전류 미러 부하 (트랜지스터 5개)
* 단자: VDD VSS IN_PLUS IN_MINUS PB OUT
* 부하 소자의 크기는 2단 NMOS(43u/1u m=3, 250 uA)와 전류밀도를 맞춘 값이다.
XMT  tail PB       VDD  VDD  pfet_06v0 w=24u l=2u m=4
XM1  d1   IN_MINUS tail tail pfet_06v0 w=40u l=1u m=2
XM2  OUT  IN_PLUS  tail tail pfet_06v0 w=40u l=1u m=2
XMN3 d1   d1       VSS  VSS  nfet_06v0 w=10.3u l=1u
XMN4 OUT  d1       VSS  VSS  nfet_06v0 w=10.3u l=1u
