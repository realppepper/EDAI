* 테스트벤치: OP-Amp - 슬루율 (단위이득 버퍼에 큰 계단 입력)
* 중괄호 자리는 run_sim.py가 채운다. 이 파일을 직접 실행하지 않는다.

.include {pdk_dir}/design.ngspice
.lib {pdk_dir}/sm141064.ngspice typical
.include {dut_file}

X1   INP OUT OUT VDD 0 opamp

VDD  VDD  0    DC {vdd}
EVCM VCM  0    VDD 0 0.5
VIN  INP  0    PULSE({v_low} {v_high} 2u 10n 10n 10u 20u)
RL   OUT  VCM  {rl}
CL   OUT  0    {cl}

.tran 5n 22u
.end
