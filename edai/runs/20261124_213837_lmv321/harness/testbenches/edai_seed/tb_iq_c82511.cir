* follower DC: VOS/IB/IOS/IQ VS=5.0
.temp 25
.options plotwinsize=0 numdgt=7
* Default Physical Device Models for AI Analog Synthesis

.model NMOS NMOS (LEVEL=1 VTO=0.7 KP=120u GAMMA=0.4 PHI=0.6 LAMBDA=0.02 TOX=10n CJ=2e-4 CJSW=1e-10 CGDO=2e-10 CGSO=2e-10)

.model PMOS PMOS (LEVEL=1 VTO=-0.7 KP=40u GAMMA=0.4 PHI=0.6 LAMBDA=0.02 TOX=10n CJ=2e-4 CJSW=1e-10 CGDO=2e-10 CGSO=2e-10)

.model QNPN NPN (IS=1e-14 BF=150 VAF=100 IKF=0.1 ISE=1e-14 NE=1.5 BR=1 VAR=100 TF=0.3n TR=10n CJE=2p CJC=1p VJC=0.75 MJC=0.33)

.model QPNP PNP (IS=1e-14 BF=80 VAF=80 IKF=0.1 ISE=1e-14 NE=1.5 BR=1 VAR=80 TF=0.5n TR=20n CJE=2p CJC=1.5p VJC=0.75 MJC=0.33)

.model D1N4148 D (IS=2.52n RS=0.568 N=1.752 CJO=4p VJ=0.5 M=0.333 BV=100 IBV=100u TT=4n)

.model D_ESD D (IS=1e-15 RS=10 CJO=1p BV=50)

* Default Physical Device Models for AI Analog Synthesis

* Default Physical Device Models for AI Analog Synthesis

.include "gf180_6v_typical.lib"

* --- Globally Hoisted Models for Multi-Subcircuit Visibility ---
.model NMOS NMOS (LEVEL=1 VTO=0.7 KP=120u GAMMA=0.4 PHI=0.6 LAMBDA=0.02 TOX=10n CJ=2e-4 CJSW=1e-10 CGDO=2e-10 CGSO=2e-10)
.model PMOS PMOS (LEVEL=1 VTO=-0.7 KP=40u GAMMA=0.4 PHI=0.6 LAMBDA=0.02 TOX=10n CJ=2e-4 CJSW=1e-10 CGDO=2e-10 CGSO=2e-10)
.model QNPN NPN (IS=1e-14 BF=150 VAF=100 IKF=0.1 ISE=1e-14 NE=1.5 BR=1 VAR=100 TF=0.3n TR=10n CJE=2p CJC=1p VJC=0.75 MJC=0.33)
.model QPNP PNP (IS=1e-14 BF=80 VAF=80 IKF=0.1 ISE=1e-14 NE=1.5 BR=1 VAR=80 TF=0.5n TR=20n CJE=2p CJC=1.5p VJC=0.75 MJC=0.33)
.model D1N4148 D (IS=2.52n RS=0.568 N=1.752 CJO=4p VJ=0.5 M=0.333 BV=100 IBV=100u TT=4n)
.model D_ESD D (IS=1e-15 RS=10 CJO=1p BV=50)

.subckt LMV321 1IN_P 1IN_N GND OUT VCC_P
MPM1 OUT VB2 VCC_P VCC_P pfet_06v0_bsim0 w=98.2u l=2u m=35
MPM6 N5 VB2 VCC_P VCC_P pfet_06v0_bsim0 w=68.7u l=2u
MPM7 N6 N7 VCC_P VCC_P pfet_06v0_bsim0 w=21.9u l=1u
MPM8 N8 N7 VCC_P VCC_P pfet_06v0_bsim0 w=21.9u l=1u
MPM9 N9 1IN_N N5 N5 pfet_06v0_bsim0 w=43.8u l=1u
MPM10 N10 1IN_P N5 N5 pfet_06v0_bsim0 w=43.7u l=1u
MPM11 N7 VB5 N6 VCC_P pfet_06v0_bsim0 w=35.5u l=1u
MPM12 N11 VB5 N8 VCC_P pfet_06v0_bsim0 w=35.5u l=1u
MNM1 OUT N11 GND GND nfet_06v0_bsim0 w=88u l=1u m=7
MNM7 N9 VB3 GND GND nfet_06v0_bsim0 w=15u l=2u
MNM8 N10 VB3 GND GND nfet_06v0_bsim0 w=15u l=2u
MNM10 N7 VB4 N9 GND nfet_06v0_bsim0 w=7.62u l=1u
MNM11 N11 VB4 N10 GND nfet_06v0_bsim0 w=7.63u l=1u
MPMB1 VB2 VB2 VCC_P VCC_P pfet_06v0_bsim0 w=68.7u l=2u
MNMF1 VB2 REF_NB GND GND nfet_06v0_bsim0 w=24u l=2u
MNMB2 VB3 VB3 GND GND nfet_06v0_bsim0 w=15u l=2u
MPMF2 VB3 REF_PB VCC_P VCC_P pfet_06v0_bsim0 w=58.6u l=2u m=2
MNMB3 VB4 VB4 VB4_S1 GND nfet_06v0_bsim0 w=14.9u l=2u
RBCVB4 VB4_S1 GND 28174.6
MPMF3 VB4 REF_PB VCC_P VCC_P pfet_06v0_bsim0 w=58.6u l=2u m=2
MPMB4 VB5 VB5 VB5_S1 VCC_P pfet_06v0_bsim0 w=72.9u l=2u
RBCVB5 VB5_S1 VCC_P 26473.2
MNMF4 VB5 REF_NB GND GND nfet_06v0_bsim0 w=24u l=2u
MREF_MN1 REF_NB REF_NB GND GND nfet_06v0_bsim0 w=12u l=2u
MREF_MN2 REF_PB REF_NB REF_NS GND nfet_06v0_bsim0 w=48u l=2u
RREF_S REF_NS GND 8353.6
MREF_MP3 REF_PB REF_PB VCC_P VCC_P pfet_06v0_bsim0 w=58.6u l=2u
MREF_MP4 REF_NB REF_PB VCC_P VCC_P pfet_06v0_bsim0 w=58.6u l=2u
MREF_MS1 REF_SX GND VCC_P VCC_P pfet_06v0_bsim0 w=0.5u l=20u
MREF_MS2 REF_PB REF_SX GND GND nfet_06v0_bsim0 w=2u l=1u
MREF_MS3 REF_SX REF_NB GND GND nfet_06v0_bsim0 w=5u l=1u
.ends LMV321

VPOS vp 0 5
VMID mid 0 2.5
VSP mid inp 0
VSN out inn 0
RL out mid 10000
CL out mid 20p
XDUT inp inn 0 out vp LMV321

.tran 0 0.00015 0 7.5e-08
.meas tran m_out AVG V(out) FROM 0.0001 TO 0.00015
.meas tran m_mid AVG V(mid) FROM 0.0001 TO 0.00015
.meas tran m_isp AVG I(VSP) FROM 0.0001 TO 0.00015
.meas tran m_isn AVG I(VSN) FROM 0.0001 TO 0.00015
.meas tran m_ipos AVG I(VPOS) FROM 0.0001 TO 0.00015
.end
