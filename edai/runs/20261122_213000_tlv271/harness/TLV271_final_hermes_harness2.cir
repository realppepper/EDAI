.include "gf180_6v_typical.lib"
.subckt TLV271 IN_P IN_N OUT GND VDD NC
MNM1 VB1 VB1 GND GND nfet_06v0_bsim0 w=15u l=2u
MNM2 VB2 VB2 GND GND nfet_06v0_bsim0 w=15u l=2u
MNM3 OUT N1 GND GND nfet_06v0_bsim0 w=90.5u l=1u m=4
MNM4 N2 VB2 GND GND nfet_06v0_bsim0 w=15u l=2u
MNM5 N1_NM5 N3 GND GND nfet_06v0_bsim0 w=5.46u l=1u
MNM6 N3_NM6 N3 GND GND nfet_06v0_bsim0 w=5.46u l=1u
MNM7 N4 N5 GND GND nfet_06v0_bsim0 w=14.9u l=2u
MNM8 N5 N5 GND GND nfet_06v0_bsim0 w=8.75u l=2u
MPM1 OUT N4 VDD VDD pfet_06v0_bsim0 w=100u l=2u m=20
MPM2 VB1 N4 VDD VDD pfet_06v0_bsim0 w=91.3u l=2u
MPM3 N1 IN_P N6 VDD pfet_06v0_bsim0 w=39.3u l=1u
MPM4 N3 IN_N N6 VDD pfet_06v0_bsim0 w=39.3u l=1u
MPM5 N6 N4 VDD VDD pfet_06v0_bsim0 w=67.5u l=2u
MPM6 N4 N4 VDD VDD pfet_06v0_bsim0 w=68.6u l=2u
MPM7 N5 N2 VDD VDD pfet_06v0_bsim0 w=40.2u l=2u
MPM8 N2 N2 VDD VDD pfet_06v0_bsim0 w=30.1u l=2u
MPM9 VB2 N2 N7 VDD pfet_06v0_bsim0 w=31.8u l=1u
R1 N7 VDD 10k
MNMC1 N1 VBCN N1_NM5 GND nfet_06v0_bsim0 w=8.45u l=1u
MNMC2 N3 VBCN N3_NM6 GND nfet_06v0_bsim0 w=8.45u l=1u
MNMB1 VBCN VBCN VBCN_S1 GND nfet_06v0_bsim0 w=14.9u l=2u
RBCVBCN VBCN_S1 GND 28174.6
MPMF1 VBCN REF_PB VDD VDD pfet_06v0_bsim0 w=58.6u l=2u m=2
MREF_MN1 REF_NB REF_NB GND GND nfet_06v0_bsim0 w=12u l=2u
MREF_MN2 REF_PB REF_NB REF_NS GND nfet_06v0_bsim0 w=48u l=2u
RREF_S REF_NS GND 8353.6
MREF_MP3 REF_PB REF_PB VDD VDD pfet_06v0_bsim0 w=58.6u l=2u
MREF_MP4 REF_NB REF_PB VDD VDD pfet_06v0_bsim0 w=58.6u l=2u
MREF_MS1 REF_SX GND VDD VDD pfet_06v0_bsim0 w=0.5u l=20u
MREF_MS2 REF_PB REF_SX GND GND nfet_06v0_bsim0 w=2u l=1u
MREF_MS3 REF_SX REF_NB GND GND nfet_06v0_bsim0 w=5u l=1u
MSU_MS1 SU_SX GND VDD VDD pfet_06v0_bsim0 w=0.5u l=20u
MSU_MS2 N2 SU_SX GND GND nfet_06v0_bsim0 w=2u l=1u
MSU_MS3 SU_SX N5 GND GND nfet_06v0_bsim0 w=5u l=1u
.ends TLV271
