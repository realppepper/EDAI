* follower DC: VOS/IB/IOS/IQ VS=5.0
.temp 25
.options plotwinsize=0 numdgt=7
* Default Physical Device Models for AI Analog Synthesis

.model NMOS NMOS (LEVEL=1 VTO=0.7 KP=120u GAMMA=0.4 PHI=0.6 LAMBDA=0.02 TOX=10n CJ=2e-4 CJSW=1e-10 CGDO=2e-10 CGSO=2e-10)

.model PMOS PMOS (LEVEL=1 VTO=-0.7 KP=40u GAMMA=0.4 PHI=0.6 LAMBDA=0.02 TOX=10n CJ=2e-4 CJSW=1e-10 CGDO=2e-10 CGSO=2e-10)

.model QNPN NPN (IS=1e-14 BF=150 VAF=100 IKF=0.1 ISE=1e-14 NE=1.5 BR=1 VAR=100 TF=0.3n TR=10n CJE=2p CJC=1p VJC=0.75 MJC=0.33)

.model QPNP PNP (IS=1e-14 BF=80 VAF=80 IKF=0.1 ISE=1e-14 NE=1.5 BR=1 VAR=80 TF=0.5n TR=20n CJE=2p CJC=1.5p VJC=0.75 MJC=0.33)

.model D1N4148 D (IS=2.52n RS=0.568 N=1.752 CJO=4p VJ=0.5 M=0.333 BV=100 IBV=100u TT=4n)

.model D_ESD D (IS=1e-15 RS=10 CJO=1p BV=50)

* Default Physical Device Models for AI Analog Synthesis

.include "gf180_6v_typical.lib"

* --- Globally Hoisted Models for Multi-Subcircuit Visibility ---
.model NMOS NMOS (LEVEL=1 VTO=0.7 KP=120u GAMMA=0.4 PHI=0.6 LAMBDA=0.02 TOX=10n CJ=2e-4 CJSW=1e-10 CGDO=2e-10 CGSO=2e-10)
.model PMOS PMOS (LEVEL=1 VTO=-0.7 KP=40u GAMMA=0.4 PHI=0.6 LAMBDA=0.02 TOX=10n CJ=2e-4 CJSW=1e-10 CGDO=2e-10 CGSO=2e-10)
.model QNPN NPN (IS=1e-14 BF=150 VAF=100 IKF=0.1 ISE=1e-14 NE=1.5 BR=1 VAR=100 TF=0.3n TR=10n CJE=2p CJC=1p VJC=0.75 MJC=0.33)
.model QPNP PNP (IS=1e-14 BF=80 VAF=80 IKF=0.1 ISE=1e-14 NE=1.5 BR=1 VAR=80 TF=0.5n TR=20n CJE=2p CJC=1.5p VJC=0.75 MJC=0.33)
.model D1N4148 D (IS=2.52n RS=0.568 N=1.752 CJO=4p VJ=0.5 M=0.333 BV=100 IBV=100u TT=4n)
.model D_ESD D (IS=1e-15 RS=10 CJO=1p BV=50)

.subckt LM358 IN1_P IN1_N OUT1 IN2_P IN2_N OUT2 V_P V_N NC1 NC2 NC3
MPM1 OUT1 VB3 V_P V_P pfet_06v0_bsim0 w=98.2u l=2u m=35
MPM4 N3 VB3 V_P V_P pfet_06v0_bsim0 w=68.7u l=2u
MPM5 N4 IN1_P N3 V_P pfet_06v0_bsim0 w=43.4u l=1u
MPM6 N5 IN1_N N3 V_P pfet_06v0_bsim0 w=43.4u l=1u
MNM3 OUT1 N4 V_N V_N nfet_06v0_bsim0 w=88u l=1u m=7
MNM5 N4_NM5 N5 V_N V_N nfet_06v0_bsim0 w=6.03u l=1u
MNM6 N5_NM6 N5 V_N V_N nfet_06v0_bsim0 w=6.03u l=1u
MNMC1 N4 VBCN N4_NM5 V_N nfet_06v0_bsim0 w=9.32u l=1u
MNMC2 N5 VBCN N5_NM6 V_N nfet_06v0_bsim0 w=9.32u l=1u
MPMB1 VB3 VB3 V_P V_P pfet_06v0_bsim0 w=68.7u l=2u
MNMF1 VB3 REF_NB V_N V_N nfet_06v0_bsim0 w=24u l=2u
MNMB2 VBCN VBCN VBCN_S1 V_N nfet_06v0_bsim0 w=14.9u l=2u
RBCVBCN VBCN_S1 V_N 28174.6
MPMF2 VBCN REF_PB V_P V_P pfet_06v0_bsim0 w=58.6u l=2u m=2
MREF_MN1 REF_NB REF_NB V_N V_N nfet_06v0_bsim0 w=12u l=2u
MREF_MN2 REF_PB REF_NB REF_NS V_N nfet_06v0_bsim0 w=48u l=2u
RREF_S REF_NS V_N 8353.6
MREF_MP3 REF_PB REF_PB V_P V_P pfet_06v0_bsim0 w=58.6u l=2u
MREF_MP4 REF_NB REF_PB V_P V_P pfet_06v0_bsim0 w=58.6u l=2u
MREF_MS1 REF_SX V_N V_P V_P pfet_06v0_bsim0 w=0.5u l=20u
MREF_MS2 REF_PB REF_SX V_N V_N nfet_06v0_bsim0 w=2u l=1u
MREF_MS3 REF_SX REF_NB V_N V_N nfet_06v0_bsim0 w=5u l=1u
MPM1_2 OUT2 VB3_2 V_P V_P pfet_06v0_bsim0 w=98.2u l=2u m=35
MPM4_2 N3_2 VB3_2 V_P V_P pfet_06v0_bsim0 w=68.7u l=2u
MPM5_2 N4_2 IN2_P N3_2 V_P pfet_06v0_bsim0 w=43.4u l=1u
MPM6_2 N5_2 IN2_N N3_2 V_P pfet_06v0_bsim0 w=43.4u l=1u
MNM3_2 OUT2 N4_2 V_N V_N nfet_06v0_bsim0 w=88u l=1u m=7
MNM5_2 N4_NM5_2 N5_2 V_N V_N nfet_06v0_bsim0 w=6.03u l=1u
MNM6_2 N5_NM6_2 N5_2 V_N V_N nfet_06v0_bsim0 w=6.03u l=1u
MNMC1_2 N4_2 VBCN_2 N4_NM5_2 V_N nfet_06v0_bsim0 w=9.32u l=1u
MNMC2_2 N5_2 VBCN_2 N5_NM6_2 V_N nfet_06v0_bsim0 w=9.32u l=1u
MPMB1_2 VB3_2 VB3_2 V_P V_P pfet_06v0_bsim0 w=68.7u l=2u
MNMF1_2 VB3_2 REF_NB_2 V_N V_N nfet_06v0_bsim0 w=24u l=2u
MNMB2_2 VBCN_2 VBCN_2 VBCN_S1_2 V_N nfet_06v0_bsim0 w=14.9u l=2u
RBCVBCN_2 VBCN_S1_2 V_N 28174.6
MPMF2_2 VBCN_2 REF_PB_2 V_P V_P pfet_06v0_bsim0 w=58.6u l=2u m=2
MREF_MN1_2 REF_NB_2 REF_NB_2 V_N V_N nfet_06v0_bsim0 w=12u l=2u
MREF_MN2_2 REF_PB_2 REF_NB_2 REF_NS_2 V_N nfet_06v0_bsim0 w=48u l=2u
RREF_S_2 REF_NS_2 V_N 8353.6
MREF_MP3_2 REF_PB_2 REF_PB_2 V_P V_P pfet_06v0_bsim0 w=58.6u l=2u
MREF_MP4_2 REF_NB_2 REF_PB_2 V_P V_P pfet_06v0_bsim0 w=58.6u l=2u
MREF_MS1_2 REF_SX_2 V_N V_P V_P pfet_06v0_bsim0 w=0.5u l=20u
MREF_MS2_2 REF_PB_2 REF_SX_2 V_N V_N nfet_06v0_bsim0 w=2u l=1u
MREF_MS3_2 REF_SX_2 REF_NB_2 V_N V_N nfet_06v0_bsim0 w=5u l=1u
.ends LM358

VPOS vp 0 5
VMID mid 0 2.5
VSP mid inp 0
VSN out inn 0
RL out mid 10000
CL out mid 20p
Rpark1 park1 mid 100k
XDUT inp inn out mid park1 park1 vp 0 nc_NC1 nc_NC2 nc_NC3 LM358

.tran 0 0.00015 0 7.5e-08
.meas tran m_out AVG V(out) FROM 0.0001 TO 0.00015
.meas tran m_mid AVG V(mid) FROM 0.0001 TO 0.00015
.meas tran m_isp AVG I(VSP) FROM 0.0001 TO 0.00015
.meas tran m_isn AVG I(VSN) FROM 0.0001 TO 0.00015
.meas tran m_ipos AVG I(VPOS) FROM 0.0001 TO 0.00015
.end
