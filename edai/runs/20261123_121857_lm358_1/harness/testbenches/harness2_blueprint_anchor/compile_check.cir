* compile check for LM358
.temp 25
.options gmin=1e-10 abstol=1e-10 reltol=0.005 itl1=500
* Default Physical Device Models for AI Analog Synthesis

.model NMOS NMOS (LEVEL=1 VTO=0.7 KP=120u GAMMA=0.4 PHI=0.6 LAMBDA=0.02 TOX=10n CJ=2e-4 CJSW=1e-10 CGDO=2e-10 CGSO=2e-10)

.model PMOS PMOS (LEVEL=1 VTO=-0.7 KP=40u GAMMA=0.4 PHI=0.6 LAMBDA=0.02 TOX=10n CJ=2e-4 CJSW=1e-10 CGDO=2e-10 CGSO=2e-10)

.model QNPN NPN (IS=1e-14 BF=150 VAF=100 IKF=0.1 ISE=1e-14 NE=1.5 BR=1 VAR=100 TF=0.3n TR=10n CJE=2p CJC=1p VJC=0.75 MJC=0.33)

.model QPNP PNP (IS=1e-14 BF=80 VAF=80 IKF=0.1 ISE=1e-14 NE=1.5 BR=1 VAR=80 TF=0.5n TR=20n CJE=2p CJC=1.5p VJC=0.75 MJC=0.33)

.model D1N4148 D (IS=2.52n RS=0.568 N=1.752 CJO=4p VJ=0.5 M=0.333 BV=100 IBV=100u TT=4n)

.model D_ESD D (IS=1e-15 RS=10 CJO=1p BV=50)

* Default Physical Device Models for AI Analog Synthesis

.include "gf180_6v_typical.lib"

* --- Globally Hoisted Models for Multi-Subcircuit Visibility ---
.model NMOS NMOS (LEVEL=1 VTO=0.7 KP=120u GAMMA=0.4 PHI=0.6 LAMBDA=0.02 TOX=10n CJ=2e-4 CJSW=1e-10 CGDO=2e-10 CGSO=2e-10)
.model PMOS PMOS (LEVEL=1 VTO=-0.7 KP=40u GAMMA=0.4 PHI=0.6 LAMBDA=0.02 TOX=10n CJ=2e-4 CJSW=1e-10 CGDO=2e-10 CGSO=2e-10)
.model QNPN NPN (IS=1e-14 BF=150 VAF=100 IKF=0.1 ISE=1e-14 NE=1.5 BR=1 VAR=100 TF=0.3n TR=10n CJE=2p CJC=1p VJC=0.75 MJC=0.33)
.model QPNP PNP (IS=1e-14 BF=80 VAF=80 IKF=0.1 ISE=1e-14 NE=1.5 BR=1 VAR=80 TF=0.5n TR=20n CJE=2p CJC=1.5p VJC=0.75 MJC=0.33)
.model D1N4148 D (IS=2.52n RS=0.568 N=1.752 CJO=4p VJ=0.5 M=0.333 BV=100 IBV=100u TT=4n)
.model D_ESD D (IS=1e-15 RS=10 CJO=1p BV=50)

.subckt LM358 IN1_P IN1_N OUT1 IN2_P IN2_N OUT2 V_P V_N NC1 NC2 NC3
MPM1 OUT1 VB3 V_P V_P pfet_06v0_bsim0 w=98.2u l=2u m=35
MPM4 N3 VB3 V_P V_P pfet_06v0_bsim0 w=68.7u l=2u
MPM5 N4 IN1_P N3 V_P pfet_06v0_bsim0 w=43.4u l=1u
MPM6 N5 IN1_N N3 V_P pfet_06v0_bsim0 w=43.4u l=1u
MNM3 OUT1 N4 V_N V_N nfet_06v0_bsim0 w=88u l=1u m=7
MNM5 N4_NM5 N5 V_N V_N nfet_06v0_bsim0 w=6.03u l=1u
MNM6 N5_NM6 N5 V_N V_N nfet_06v0_bsim0 w=6.03u l=1u
MNMC1 N4 VBCN N4_NM5 V_N nfet_06v0_bsim0 w=9.32u l=1u
MNMC2 N5 VBCN N5_NM6 V_N nfet_06v0_bsim0 w=9.32u l=1u
MPMB1 VB3 VB3 V_P V_P pfet_06v0_bsim0 w=68.7u l=2u
MNMF1 VB3 REF_NB V_N V_N nfet_06v0_bsim0 w=24u l=2u
MNMB2 VBCN VBCN VBCN_S1 V_N nfet_06v0_bsim0 w=14.9u l=2u
RBCVBCN VBCN_S1 V_N 28174.6
MPMF2 VBCN REF_PB V_P V_P pfet_06v0_bsim0 w=58.6u l=2u m=2
MREF_MN1 REF_NB REF_NB V_N V_N nfet_06v0_bsim0 w=12u l=2u
MREF_MN2 REF_PB REF_NB REF_NS V_N nfet_06v0_bsim0 w=48u l=2u
RREF_S REF_NS V_N 8353.6
MREF_MP3 REF_PB REF_PB V_P V_P pfet_06v0_bsim0 w=58.6u l=2u
MREF_MP4 REF_NB REF_PB V_P V_P pfet_06v0_bsim0 w=58.6u l=2u
MREF_MS1 REF_SX V_N V_P V_P pfet_06v0_bsim0 w=0.5u l=20u
MREF_MS2 REF_PB REF_SX V_N V_N nfet_06v0_bsim0 w=2u l=1u
MREF_MS3 REF_SX REF_NB V_N V_N nfet_06v0_bsim0 w=5u l=1u
MPM1_2 OUT2 VB3_2 V_P V_P pfet_06v0_bsim0 w=98.2u l=2u m=35
MPM4_2 N3_2 VB3_2 V_P V_P pfet_06v0_bsim0 w=68.7u l=2u
MPM5_2 N4_2 IN2_P N3_2 V_P pfet_06v0_bsim0 w=43.4u l=1u
MPM6_2 N5_2 IN2_N N3_2 V_P pfet_06v0_bsim0 w=43.4u l=1u
MNM3_2 OUT2 N4_2 V_N V_N nfet_06v0_bsim0 w=88u l=1u m=7
MNM5_2 N4_NM5_2 N5_2 V_N V_N nfet_06v0_bsim0 w=6.03u l=1u
MNM6_2 N5_NM6_2 N5_2 V_N V_N nfet_06v0_bsim0 w=6.03u l=1u
MNMC1_2 N4_2 VBCN_2 N4_NM5_2 V_N nfet_06v0_bsim0 w=9.32u l=1u
MNMC2_2 N5_2 VBCN_2 N5_NM6_2 V_N nfet_06v0_bsim0 w=9.32u l=1u
MPMB1_2 VB3_2 VB3_2 V_P V_P pfet_06v0_bsim0 w=68.7u l=2u
MNMF1_2 VB3_2 REF_NB_2 V_N V_N nfet_06v0_bsim0 w=24u l=2u
MNMB2_2 VBCN_2 VBCN_2 VBCN_S1_2 V_N nfet_06v0_bsim0 w=14.9u l=2u
RBCVBCN_2 VBCN_S1_2 V_N 28174.6
MPMF2_2 VBCN_2 REF_PB_2 V_P V_P pfet_06v0_bsim0 w=58.6u l=2u m=2
MREF_MN1_2 REF_NB_2 REF_NB_2 V_N V_N nfet_06v0_bsim0 w=12u l=2u
MREF_MN2_2 REF_PB_2 REF_NB_2 REF_NS_2 V_N nfet_06v0_bsim0 w=48u l=2u
RREF_S_2 REF_NS_2 V_N 8353.6
MREF_MP3_2 REF_PB_2 REF_PB_2 V_P V_P pfet_06v0_bsim0 w=58.6u l=2u
MREF_MP4_2 REF_NB_2 REF_PB_2 V_P V_P pfet_06v0_bsim0 w=58.6u l=2u
MREF_MS1_2 REF_SX_2 V_N V_P V_P pfet_06v0_bsim0 w=0.5u l=20u
MREF_MS2_2 REF_PB_2 REF_SX_2 V_N V_N nfet_06v0_bsim0 w=2u l=1u
MREF_MS3_2 REF_SX_2 REF_NB_2 V_N V_N nfet_06v0_bsim0 w=5u l=1u
.ends LM358

R_1_n_IN1_P n_IN1_P 0 1G
R_2_n_IN1_N n_IN1_N 0 1G
R_3_n_OUT1 n_OUT1 0 1G
R_4_n_IN2_P n_IN2_P 0 1G
R_5_n_IN2_N n_IN2_N 0 1G
R_6_n_OUT2 n_OUT2 0 1G
R_7_n_V_P n_V_P 0 1G
R_8_n_V_N n_V_N 0 1G
R_9_n_NC1 n_NC1 0 1G
R_10_n_NC2 n_NC2 0 1G
R_11_n_NC3 n_NC3 0 1G
VPOS n_V_P 0 5
VNEG n_V_N 0 0
XDUT n_IN1_P n_IN1_N n_OUT1 n_IN2_P n_IN2_N n_OUT2 n_V_P n_V_N n_NC1 n_NC2 n_NC3 LM358
.op
.end
