.include "gf180_6v_typical.lib"
.subckt LM358 IN1_P IN1_N OUT1 IN2_P IN2_N OUT2 V_P V_N NC1 NC2 NC3
MPM1 OUT1 VB3 V_P V_P pfet_06v0_bsim0 w=98.2u l=2u m=35
MPM4 N3 VB3 V_P V_P pfet_06v0_bsim0 w=68.7u l=2u
MPM5 N4 IN1_P N3 V_P pfet_06v0_bsim0 w=43.4u l=1u
MPM6 N5 IN1_N N3 V_P pfet_06v0_bsim0 w=43.4u l=1u
MNM3 OUT1 N4 V_N V_N nfet_06v0_bsim0 w=88u l=1u m=7
MNM5 N4_NM5 N5 V_N V_N nfet_06v0_bsim0 w=6.03u l=1u
MNM6 N5_NM6 N5 V_N V_N nfet_06v0_bsim0 w=6.03u l=1u
MNMC1 N4 VBCN N4_NM5 V_N nfet_06v0_bsim0 w=9.32u l=1u
MNMC2 N5 VBCN N5_NM6 V_N nfet_06v0_bsim0 w=9.32u l=1u
MPMB1 VB3 VB3 V_P V_P pfet_06v0_bsim0 w=68.7u l=2u
MNMF1 VB3 REF_NB V_N V_N nfet_06v0_bsim0 w=24u l=2u
MNMB2 VBCN VBCN VBCN_S1 V_N nfet_06v0_bsim0 w=14.9u l=2u
RBCVBCN VBCN_S1 V_N 28174.6
MPMF2 VBCN REF_PB V_P V_P pfet_06v0_bsim0 w=58.6u l=2u m=2
MREF_MN1 REF_NB REF_NB V_N V_N nfet_06v0_bsim0 w=12u l=2u
MREF_MN2 REF_PB REF_NB REF_NS V_N nfet_06v0_bsim0 w=48u l=2u
RREF_S REF_NS V_N 8353.6
MREF_MP3 REF_PB REF_PB V_P V_P pfet_06v0_bsim0 w=58.6u l=2u
MREF_MP4 REF_NB REF_PB V_P V_P pfet_06v0_bsim0 w=58.6u l=2u
MREF_MS1 REF_SX V_N V_P V_P pfet_06v0_bsim0 w=0.5u l=20u
MREF_MS2 REF_PB REF_SX V_N V_N nfet_06v0_bsim0 w=2u l=1u
MREF_MS3 REF_SX REF_NB V_N V_N nfet_06v0_bsim0 w=5u l=1u
MPM1_2 OUT2 VB3_2 V_P V_P pfet_06v0_bsim0 w=98.2u l=2u m=35
MPM4_2 N3_2 VB3_2 V_P V_P pfet_06v0_bsim0 w=68.7u l=2u
MPM5_2 N4_2 IN2_P N3_2 V_P pfet_06v0_bsim0 w=43.4u l=1u
MPM6_2 N5_2 IN2_N N3_2 V_P pfet_06v0_bsim0 w=43.4u l=1u
MNM3_2 OUT2 N4_2 V_N V_N nfet_06v0_bsim0 w=88u l=1u m=7
MNM5_2 N4_NM5_2 N5_2 V_N V_N nfet_06v0_bsim0 w=6.03u l=1u
MNM6_2 N5_NM6_2 N5_2 V_N V_N nfet_06v0_bsim0 w=6.03u l=1u
MNMC1_2 N4_2 VBCN_2 N4_NM5_2 V_N nfet_06v0_bsim0 w=9.32u l=1u
MNMC2_2 N5_2 VBCN_2 N5_NM6_2 V_N nfet_06v0_bsim0 w=9.32u l=1u
MPMB1_2 VB3_2 VB3_2 V_P V_P pfet_06v0_bsim0 w=68.7u l=2u
MNMF1_2 VB3_2 REF_NB_2 V_N V_N nfet_06v0_bsim0 w=24u l=2u
MNMB2_2 VBCN_2 VBCN_2 VBCN_S1_2 V_N nfet_06v0_bsim0 w=14.9u l=2u
RBCVBCN_2 VBCN_S1_2 V_N 28174.6
MPMF2_2 VBCN_2 REF_PB_2 V_P V_P pfet_06v0_bsim0 w=58.6u l=2u m=2
MREF_MN1_2 REF_NB_2 REF_NB_2 V_N V_N nfet_06v0_bsim0 w=12u l=2u
MREF_MN2_2 REF_PB_2 REF_NB_2 REF_NS_2 V_N nfet_06v0_bsim0 w=48u l=2u
RREF_S_2 REF_NS_2 V_N 8353.6
MREF_MP3_2 REF_PB_2 REF_PB_2 V_P V_P pfet_06v0_bsim0 w=58.6u l=2u
MREF_MP4_2 REF_NB_2 REF_PB_2 V_P V_P pfet_06v0_bsim0 w=58.6u l=2u
MREF_MS1_2 REF_SX_2 V_N V_P V_P pfet_06v0_bsim0 w=0.5u l=20u
MREF_MS2_2 REF_PB_2 REF_SX_2 V_N V_N nfet_06v0_bsim0 w=2u l=1u
MREF_MS3_2 REF_SX_2 REF_NB_2 V_N V_N nfet_06v0_bsim0 w=5u l=1u
.ends LM358
