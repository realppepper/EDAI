* --- Globally Hoisted Models for Multi-Subcircuit Visibility ---
.model D1N4148 D(IS=1e-14 RS=1)
.model QNPN NPN(IS=1e-16 BF=250 VAF=120)
.model QPNP PNP(IS=1e-16 BF=100 VAF=100)

.subckt LM358 IN1_P IN1_N OUT1 IN2_P IN2_N OUT2 V_P V_N NC1 NC2 NC3
* Synthesized via CircuitBuilder IR (strict physical SPICE)
RBIAS IN1_P N_BIAS 300k
Q_BREF N_BIAS N_BIAS N_EREF QNPN
RE_BREF N_EREF IN1_N 2k
Q_TAIL N_TAIL N_BIAS N_ETAIL QNPN
RE_TAIL N_ETAIL IN1_N 2k
Q_IN1 N_C1 INN N_TAIL QNPN
Q_IN2 N_C2 INP N_TAIL QNPN
Q_ML1 N_C1 N_C1 N_ME1 QPNP
RM_L1 IN1_P N_ME1 500
Q_ML2 N_C2 N_C1 N_ME2 QPNP
RM_L2 IN1_P N_ME2 500
Q_G2 N_G2 N_C2 IN1_P QPNP
Q_G2L N_G2 N_BIAS N_EG2L QNPN
RE_G2L N_EG2L IN1_N 1k
RZ_COMP N_C2 N_CZ 1k
CC_COMP N_CZ N_G2 30p
Q_AB_BUF IN1_P N_G2 N_AB_TOP QNPN
D_AB1 N_AB_TOP N_AB_MID D1N4148
D_AB2 N_AB_MID N_AB_BOT D1N4148
Q_AB_SINK N_AB_BOT N_BIAS N_E_ABSINK QNPN
RE_ABSINK N_E_ABSINK IN1_N 2k
Q_OUTN IN1_P N_AB_TOP N_EOUTN QNPN
RE_OUTN N_EOUTN OUT1 25
Q_OUTP IN1_N N_AB_BOT N_EOUTP QPNP
RE_OUTP N_EOUTP OUT1 25
D_AB1_2 IN1_N IN1_N D1N4148
D_AB2_2 IN1_N IN1_N D1N4148
RE_ABSINK_2 IN1_N IN1_N 2k
RE_OUTN_2 IN1_N IN1_N 25
RE_OUTP_2 IN1_N IN1_N 25
D1 IN1_N IN1_N D1N4148
R1 IN1_N IN1_N 10k
R2 IN1_N IN1_N 10k
.ends LM358
