* Default Physical Device Models for AI Analog Synthesis

.model NMOS NMOS (LEVEL=1 VTO=0.7 KP=120u GAMMA=0.4 PHI=0.6 LAMBDA=0.02 TOX=10n CJ=2e-4 CJSW=1e-10 CGDO=2e-10 CGSO=2e-10)

.model PMOS PMOS (LEVEL=1 VTO=-0.7 KP=40u GAMMA=0.4 PHI=0.6 LAMBDA=0.02 TOX=10n CJ=2e-4 CJSW=1e-10 CGDO=2e-10 CGSO=2e-10)

.model QNPN NPN (IS=1e-14 BF=150 VAF=100 IKF=0.1 ISE=1e-14 NE=1.5 BR=1 VAR=100 TF=0.3n TR=10n CJE=2p CJC=1p VJC=0.75 MJC=0.33)

.model QPNP PNP (IS=1e-14 BF=80 VAF=80 IKF=0.1 ISE=1e-14 NE=1.5 BR=1 VAR=80 TF=0.5n TR=20n CJE=2p CJC=1.5p VJC=0.75 MJC=0.33)

.model D1N4148 D (IS=2.52n RS=0.568 N=1.752 CJO=4p VJ=0.5 M=0.333 BV=100 IBV=100u TT=4n)

.model D_ESD D (IS=1e-15 RS=10 CJO=1p BV=50)

* Default Physical Device Models for AI Analog Synthesis

* --- Globally Hoisted Models for Multi-Subcircuit Visibility ---
.model NMOS NMOS (LEVEL=1 VTO=0.7 KP=120u GAMMA=0.4 PHI=0.6 LAMBDA=0.02 TOX=10n CJ=2e-4 CJSW=1e-10 CGDO=2e-10 CGSO=2e-10)
.model PMOS PMOS (LEVEL=1 VTO=-0.7 KP=40u GAMMA=0.4 PHI=0.6 LAMBDA=0.02 TOX=10n CJ=2e-4 CJSW=1e-10 CGDO=2e-10 CGSO=2e-10)
.model QNPN NPN (IS=1e-14 BF=150 VAF=100 IKF=0.1 ISE=1e-14 NE=1.5 BR=1 VAR=100 TF=0.3n TR=10n CJE=2p CJC=1p VJC=0.75 MJC=0.33)
.model QPNP PNP (IS=1e-14 BF=80 VAF=80 IKF=0.1 ISE=1e-14 NE=1.5 BR=1 VAR=80 TF=0.5n TR=20n CJE=2p CJC=1.5p VJC=0.75 MJC=0.33)
.model D1N4148 D (IS=2.52n RS=0.568 N=1.752 CJO=4p VJ=0.5 M=0.333 BV=100 IBV=100u TT=4n)
.model D_ESD D (IS=1e-15 RS=10 CJO=1p BV=50)

.subckt LM324B 1IN_P 1IN_N 1OUT 2IN_P 2IN_N 2OUT 3IN_P 3IN_N 3OUT 4IN_P 4IN_N 4OUT VCC_P VCC_N NC
* 1. DC Biasing and Current Mirrors (150μA per channel)
* 2. Core Functional Blocks (Differential Pair, Gain Stage, Output Buffer)
* 3. Explicit Device Models
* 1. Input Differential Pair (PMOS)
M1 1IN_P 1IN_N VCC_P VCC_P MPM1 NMOS W=10u L=0.5u
M2 1IN_P 1IN_N VCC_P VCC_P MPM2 NMOS W=10u L=0.5u
* 2. Input Differential Pair (NMOS)
M3 2IN_P 2IN_N VCC_P VCC_P MNM1 NMOS W=10u L=0.5u
M4 2IN_P 2IN_N VCC_P VCC_P MNM2 NMOS W=10u L=0.5u
* 3. Input Differential Pair (PMOS)
M5 3IN_P 3IN_N VCC_P VCC_P MPM3 NMOS W=10u L=0.5u
M6 3IN_P 3IN_N VCC_P VCC_P MPM4 NMOS W=10u L=0.5u
* 4. Input Differential Pair (NMOS)
M7 4IN_P 4IN_N VCC_P VCC_P MNM3 NMOS W=10u L=0.5u
M8 4IN_P 4IN_N VCC_P VCC_P MNM4 NMOS W=10u L=0.5u
* 5. Cascode Current Mirrors (150μA)
M9 1OUT 2IN_P VCC_P VCC_P MNM5 MNOS W=20u L=0.5u
M10 1OUT 2IN_N VCC_P VCC_P MNM6 NMOS W=20u L=0.5u
M11 2OUT 3IN_P VCC_P VCC_P MNM7 MNOS W=20u L=0.5u
M12 2OUT 3IN_N VCC_P VCC_P MNM8 NMOS W=20u L=0.5u
M13 3OUT 4IN_P VCC_P VCC_P MNM9 MNOS W=20u L=0.5u
M14 3OUT 4IN_N VCC_P VCC_P MNM10 NMOS W=20u L=0.5u
* 6. Output Stage (PMOS)
M15 1OUT VCC_P VCC_P VCC_P MPM5 PMOS W=20u L=0.5u
M16 2OUT VCC_P VCC_P VCC_P MPM6 PMOS W=20u L=0.5u
M17 3OUT VCC_P VCC_P VCC_P MPM7 PMOS W=20u L=0.5u
M18 4OUT VCC_P VCC_P VCC_P MPM8 PMOS W=20u L=0.5u
* 7. Supply Bypass Capacitors (100pF)
C1 VCC_P VCC_N 100p
C2 1OUT VCC_N 100p
C3 2OUT VCC_N 100p
C4 3OUT VCC_N 100p
C5 4OUT VCC_N 100p
* 8. Ground Connections (VCC_N tied to 0V externally)
.ends LM324B
