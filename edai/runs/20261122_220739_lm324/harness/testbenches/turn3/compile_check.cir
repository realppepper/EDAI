* compile check for LM324B
.temp 25
.options gmin=1e-10 abstol=1e-10 reltol=0.005 itl1=500
* Default Physical Device Models for AI Analog Synthesis

.model NMOS NMOS (LEVEL=1 VTO=0.7 KP=120u GAMMA=0.4 PHI=0.6 LAMBDA=0.02 TOX=10n CJ=2e-4 CJSW=1e-10 CGDO=2e-10 CGSO=2e-10)

.model PMOS PMOS (LEVEL=1 VTO=-0.7 KP=40u GAMMA=0.4 PHI=0.6 LAMBDA=0.02 TOX=10n CJ=2e-4 CJSW=1e-10 CGDO=2e-10 CGSO=2e-10)

.model QNPN NPN (IS=1e-14 BF=150 VAF=100 IKF=0.1 ISE=1e-14 NE=1.5 BR=1 VAR=100 TF=0.3n TR=10n CJE=2p CJC=1p VJC=0.75 MJC=0.33)

.model QPNP PNP (IS=1e-14 BF=80 VAF=80 IKF=0.1 ISE=1e-14 NE=1.5 BR=1 VAR=80 TF=0.5n TR=20n CJE=2p CJC=1.5p VJC=0.75 MJC=0.33)

.model D1N4148 D (IS=2.52n RS=0.568 N=1.752 CJO=4p VJ=0.5 M=0.333 BV=100 IBV=100u TT=4n)

.model D_ESD D (IS=1e-15 RS=10 CJO=1p BV=50)

* Default Physical Device Models for AI Analog Synthesis

* Default Physical Device Models for AI Analog Synthesis

* --- Globally Hoisted Models for Multi-Subcircuit Visibility ---
.model NMOS NMOS (LEVEL=1 VTO=0.7 KP=120u GAMMA=0.4 PHI=0.6 LAMBDA=0.02 TOX=10n CJ=2e-4 CJSW=1e-10 CGDO=2e-10 CGSO=2e-10)
.model PMOS PMOS (LEVEL=1 VTO=-0.7 KP=40u GAMMA=0.4 PHI=0.6 LAMBDA=0.02 TOX=10n CJ=2e-4 CJSW=1e-10 CGDO=2e-10 CGSO=2e-10)
.model QNPN NPN (IS=1e-14 BF=150 VAF=100 IKF=0.1 ISE=1e-14 NE=1.5 BR=1 VAR=100 TF=0.3n TR=10n CJE=2p CJC=1p VJC=0.75 MJC=0.33)
.model QPNP PNP (IS=1e-14 BF=80 VAF=80 IKF=0.1 ISE=1e-14 NE=1.5 BR=1 VAR=80 TF=0.5n TR=20n CJE=2p CJC=1.5p VJC=0.75 MJC=0.33)
.model D1N4148 D (IS=2.52n RS=0.568 N=1.752 CJO=4p VJ=0.5 M=0.333 BV=100 IBV=100u TT=4n)
.model D_ESD D (IS=1e-15 RS=10 CJO=1p BV=50)

.subckt LM324B 1IN_P 1IN_N 1OUT 2IN_P 2IN_N 2OUT 3IN_P 3IN_N 3OUT 4IN_P 4IN_N 4OUT VCC_P VCC_N NC
MNM3 1OUT N1 VCC_N VCC_N nfet_06v0_bsim0 w=150u l=2u m=5
MNM6 N4 N5 VCC_N VCC_N nfet_06v0_bsim0 w=14.4u l=2u
MNM7 N1 N1 VCC_N VCC_N nfet_06v0_bsim0 w=7.66u l=2u
MNM8 N5 N5 VCC_N VCC_N nfet_06v0_bsim0 w=8.56u l=2u
MPM1 1OUT N4 VCC_P VCC_P pfet_06v0_bsim0 w=80u l=2u m=20
MPM3 N4 N4 VCC_P VCC_P pfet_06v0_bsim0 w=66.5u l=2u
MPM4 N1 1IN_P N6 VCC_P pfet_06v0_bsim0 w=41u l=1u
MPM5 N5 1IN_N N6 VCC_P pfet_06v0_bsim0 w=45.8u l=1u
MPM6 N6 VB3 VCC_P VCC_P pfet_06v0_bsim0 w=68.7u l=2u
C1 1OUT N1 10p
MPMB1 VB3 VB3 VCC_P VCC_P pfet_06v0_bsim0 w=68.7u l=2u
MNMF1 VB3 REF_NB VCC_N VCC_N nfet_06v0_bsim0 w=24u l=2u
MREF_MN1 REF_NB REF_NB VCC_N VCC_N nfet_06v0_bsim0 w=12u l=2u
MREF_MN2 REF_PB REF_NB REF_NS VCC_N nfet_06v0_bsim0 w=48u l=2u
RREF_S REF_NS VCC_N 1k
MREF_MP3 REF_PB REF_PB VCC_P VCC_P pfet_06v0_bsim0 w=58.6u l=2u
MREF_MP4 REF_NB REF_PB VCC_P VCC_P pfet_06v0_bsim0 w=58.6u l=2u
MREF_MS1 REF_SX VCC_N VCC_P VCC_P pfet_06v0_bsim0 w=0.5u l=20u
MREF_MS2 REF_PB REF_SX VCC_N VCC_N nfet_06v0_bsim0 w=2u l=1u
MREF_MS3 REF_SX REF_NB VCC_N VCC_N nfet_06v0_bsim0 w=5u l=1u
MNM3_2 2OUT N1_2 VCC_N VCC_N nfet_06v0_bsim0 w=150u l=2u m=5
MNM6_2 N4_2 N5_2 VCC_N VCC_N nfet_06v0_bsim0 w=14.4u l=2u
MNM7_2 N1_2 N1_2 VCC_N VCC_N nfet_06v0_bsim0 w=7.66u l=2u
MNM8_2 N5_2 N5_2 VCC_N VCC_N nfet_06v0_bsim0 w=8.56u l=2u
MPM1_2 2OUT N4_2 VCC_P VCC_P pfet_06v0_bsim0 w=80u l=2u m=20
MPM3_2 N4_2 N4_2 VCC_P VCC_P pfet_06v0_bsim0 w=66.5u l=2u
MPM4_2 N1_2 2IN_P N6_2 VCC_P pfet_06v0_bsim0 w=41u l=1u
MPM5_2 N5_2 2IN_N N6_2 VCC_P pfet_06v0_bsim0 w=45.8u l=1u
MPM6_2 N6_2 VB3_2 VCC_P VCC_P pfet_06v0_bsim0 w=68.7u l=2u
C1_2 2OUT N1_2 10p
MPMB1_2 VB3_2 VB3_2 VCC_P VCC_P pfet_06v0_bsim0 w=68.7u l=2u
MNMF1_2 VB3_2 REF_NB_2 VCC_N VCC_N nfet_06v0_bsim0 w=24u l=2u
MREF_MN1_2 REF_NB_2 REF_NB_2 VCC_N VCC_N nfet_06v0_bsim0 w=12u l=2u
MREF_MN2_2 REF_PB_2 REF_NB_2 REF_NS_2 VCC_N nfet_06v0_bsim0 w=48u l=2u
RREF_S_2 REF_NS_2 VCC_N 1k
MREF_MP3_2 REF_PB_2 REF_PB_2 VCC_P VCC_P pfet_06v0_bsim0 w=58.6u l=2u
MREF_MP4_2 REF_NB_2 REF_PB_2 VCC_P VCC_P pfet_06v0_bsim0 w=58.6u l=2u
MREF_MS1_2 REF_SX_2 VCC_N VCC_P VCC_P pfet_06v0_bsim0 w=0.5u l=20u
MREF_MS2_2 REF_PB_2 REF_SX_2 VCC_N VCC_N nfet_06v0_bsim0 w=2u l=1u
MREF_MS3_2 REF_SX_2 REF_NB_2 VCC_N VCC_N nfet_06v0_bsim0 w=5u l=1u
MNM3_3 3OUT N1_3 VCC_N VCC_N nfet_06v0_bsim0 w=150u l=2u m=5
MNM6_3 N4_3 N5_3 VCC_N VCC_N nfet_06v0_bsim0 w=14.4u l=2u
MNM7_3 N1_3 N1_3 VCC_N VCC_N nfet_06v0_bsim0 w=7.66u l=2u
MNM8_3 N5_3 N5_3 VCC_N VCC_N nfet_06v0_bsim0 w=8.56u l=2u
MPM1_3 3OUT N4_3 VCC_P VCC_P pfet_06v0_bsim0 w=80u l=2u m=20
MPM3_3 N4_3 N4_3 VCC_P VCC_P pfet_06v0_bsim0 w=66.5u l=2u
MPM4_3 N1_3 3IN_P N6_3 VCC_P pfet_06v0_bsim0 w=41u l=1u
MPM5_3 N5_3 3IN_N N6_3 VCC_P pfet_06v0_bsim0 w=45.8u l=1u
MPM6_3 N6_3 VB3_3 VCC_P VCC_P pfet_06v0_bsim0 w=68.7u l=2u
C1_3 3OUT N1_3 10p
MPMB1_3 VB3_3 VB3_2 VCC_P VCC_P pfet_06v0_bsim0 w=68.7u l=2u
MNMF1_3 VB3_3 REF_NB_3 VCC_N VCC_N nfet_06v0_bsim0 w=24u l=2u
MREF_MN1_3 REF_NB_3 REF_NB_3 VCC_N VCC_N nfet_06v0_bsim0 w=12u l=2u
MREF_MN2_3 REF_PB_3 REF_NB_3 REF_NS_3 VCC_N nfet_06v0_bsim0 w=48u l=2u
RREF_S_3 REF_NS_3 VCC_N 1k
MREF_MP3_3 REF_PB_3 REF_PB_3 VCC_P VCC_P pfet_06v0_bsim0 w=58.6u l=2u
MREF_MP4_3 REF_NB_3 REF_PB_3 VCC_P VCC_P pfet_06v0_bsim0 w=58.6u l=2u
MREF_MS1_3 REF_SX_3 VCC_N VCC_P VCC_P pfet_06v0_bsim0 w=0.5u l=20u
MREF_MS2_3 REF_PB_3 REF_SX_3 VCC_N VCC_N nfet_06v0_bsim0 w=2u l=1u
MREF_MS3_3 REF_SX_3 REF_NB_3 VCC_N VCC_N nfet_06v0_bsim0 w=5u l=1u
MNM3_4 4OUT N1_4 VCC_N VCC_N nfet_06v0_bsim0 w=150u l=2u m=5
MNM6_4 N4_4 N5_4 VCC_N VCC_N nfet_06v0_bsim0 w=14.4u l=2u
MNM7_4 N1_4 N1_4 VCC_N VCC_N nfet_06v0_bsim0 w=7.66u l=2u
MNM8_4 N5_4 N5_4 VCC_N VCC_N nfet_06v0_bsim0 w=8.56u l=2u
MPM1_4 4OUT N4_4 VCC_P VCC_P pfet_06v0_bsim0 w=80u l=2u m=20
MPM3_4 N4_4 N4_4 VCC_P VCC_P pfet_06v0_bsim0 w=66.5u l=2u
MPM4_4 N1_4 4IN_P N6_4 VCC_P pfet_06v0_bsim0 w=41u l=1u
MPM5_4 N5_4 4IN_N N6_4 VCC_P pfet_06v0_bsim0 w=45.8u l=1u
MPM6_4 N6_4 VB3_4 VCC_P VCC_P pfet_06v0_bsim0 w=68.7u l=2u
C1_4 4OUT N1_4 10p
MPMB1_4 VB3_4 VB3_4 VCC_P VCC_P pfet_06v0_bsim0 w=68.7u l=2u
MNMF1_4 VB3_4 REF_NB_4 VCC_N VCC_N nfet_06v0_bsim0 w=24u l=2u
MREF_MN1_4 REF_NB_4 REF_NB_4 VCC_N VCC_N nfet_06v0_bsim0 w=12u l=2u
MREF_MN2_4 REF_PB_4 REF_NB_4 REF_NS_4 VCC_N nfet_06v0_bsim0 w=48u l=2u
RREF_S_4 REF_NS_4 VCC_N 1k
MREF_MP3_4 REF_PB_4 REF_PB_4 VCC_P VCC_P pfet_06v0_bsim0 w=58.6u l=2u
MREF_MP4_4 REF_NB_4 REF_PB_4 VCC_P VCC_P pfet_06v0_bsim0 w=58.6u l=2u
MREF_MS1_4 REF_SX_4 VCC_N VCC_P VCC_P pfet_06v0_bsim0 w=0.5u l=20u
MREF_MS2_4 REF_PB_4 REF_SX_4 VCC_N VCC_N nfet_06v0_bsim0 w=2u l=1u
MREF_MS3_4 REF_SX_4 REF_NB_4 VCC_N VCC_N nfet_06v0_bsim0 w=5u l=1u
.ends LM324B

R_1_n_1IN_P n_1IN_P 0 1G
R_2_n_1IN_N n_1IN_N 0 1G
R_3_n_1OUT n_1OUT 0 1G
R_4_n_2IN_P n_2IN_P 0 1G
R_5_n_2IN_N n_2IN_N 0 1G
R_6_n_2OUT n_2OUT 0 1G
R_7_n_3IN_P n_3IN_P 0 1G
R_8_n_3IN_N n_3IN_N 0 1G
R_9_n_3OUT n_3OUT 0 1G
R_10_n_4IN_P n_4IN_P 0 1G
R_11_n_4IN_N n_4IN_N 0 1G
R_12_n_4OUT n_4OUT 0 1G
R_13_n_VCC_P n_VCC_P 0 1G
R_14_n_VCC_N n_VCC_N 0 1G
R_15_n_NC n_NC 0 1G
VPOS n_VCC_P 0 15
VNEG n_VCC_N 0 0
XDUT n_1IN_P n_1IN_N n_1OUT n_2IN_P n_2IN_N n_2OUT n_3IN_P n_3IN_N n_3OUT n_4IN_P n_4IN_N n_4OUT n_VCC_P n_VCC_N n_NC LM324B
.op
.end
