* Advanced Dynamic Testbench for LM358B
.include LM358B_iter2_probe_b.cir
XDUT IN1_P IN1_N IN2_P IN2_N OUT1 OUT2 V_P V_N NC LM358B

* Power and Grounding
V_V_N V_N 0 0
V_V_P V_P 0 15

* Dynamic Signal Stimulus (Input 1)
VINP IN1_P 0 SINE(2.5 0.1 1k 10u)
VINN IN1_N 0 DC 2.5

* Load Termination (RL = 100k specified, using 10k as per mandatory directive 4)
RL OUT1 0 10k

* Simulation Control
.tran 10u 20m 10m

* Measurements (THD/RMS/ICC approximations based on directives)
.four 1k 9 V(OUT1)
.meas tran v_rms RMS V(OUT1) from=15m to=20m
.meas tran icc AVG -I(V_V_P) from=10m to=20m

* Note: Crosstalk measurements require AC analysis or specific time-domain setup not fully defined by mandatory directives.
* THD/IOUT constraints require specific load/source conditions not fully implemented by simplified directives.

.control
run
.endc
.end
