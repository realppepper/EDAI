* Advanced Dynamic Testbench
.include LM358B_harness2_blueprint_anchor.cir
XDUT IN1_P IN1_N IN2_P IN2_N OUT1 OUT2 V_P V_N NC LM358B

* Power and Grounding
V_V_N V_N 0 0
V_V_P V_P 0 15

* Dynamic Signal Stimulus (Focusing on Channel 1 for THD measurement)
VINP IN1_P 0 SINE(2.5 0.1 1k 10u)
VINN IN1_N 0 DC 2.5

* Load Termination (RL = 100k specified in THD, using 10k as per mandatory directive 4)
RL OUT1 0 10k

* Simulation Control
.tran 10u 20m 10m

* Measurements (THD related)
.four 1k 9 V(OUT1)
.meas tran v_rms RMS V(OUT1) from=15m to=20m
.meas tran icc AVG -I(V_V_P) from=10m to=20m

* Note: Crosstalk measurements require AC analysis or specific transient setups not fully supported by the mandatory single .tran directive.
* The THD measurement setup is implemented based on provided directives.

.control
run
.endc
.end
