* NMOS-input Cascode Amplifier - 회로 본체 (설계 대상)
* Case 1 - 예비캡스톤설계 (ngspice)
* 전원, 입력 신호, 부하, 해석 명령은 테스트벤치(tb_cascode_*.cir)에 있다.
* 재설계할 때는 이 파일의 소자 값만 고친다.

.model NMOS1 NMOS (LEVEL=1 VTO=0.7 KP=200u LAMBDA=0.02)

.subckt cascode VIN VCASC VOUT VDD
RD  VDD VOUT 1.5k
M1  VX   VIN   0  0  NMOS1 W=250u L=1u
M2  VOUT VCASC VX VX NMOS1 W=250u L=1u
.ends cascode
